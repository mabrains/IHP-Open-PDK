* =========================================================================================
* Copyright 2025 IHP PDK Authors
*
* Licensed under the Apache License, Version 2.0 (the "License");
* you may not use this file except in compliance with the License.
* You may obtain a copy of the License at
*
*     https://www.apache.org/licenses/LICENSE-2.0
*
* Unless required by applicable law or agreed to in writing, software
* distributed under the License is distributed on an "AS IS" BASIS,
* WITHOUT WARRANTIES OR CONDITIONS OF ANY KIND, either express or implied.
* See the License for the specific language governing permissions and
* limitations under the License.
* =========================================================================================

*********
*Sources*
*********

Ib 0 b -1e-06
Vc c 0 0.0
Ve e 0 0.0

*********
*Circuit*
*********

X1 c b e pnpMPA a= 6.799999999999999e-07 p= 3.36e-06 m=1

* ============================================================================================
* ----------------------------------------- ANALYSIS -----------------------------------------
* ============================================================================================

.temp 27.0

.control
  set filetype=ascii
  set wr_singlescale
  set wr_vecnames

  dc Vc 0 -5 -0.05

  let ic = -i(Vc)
  let ib = -i(Vb)
  let ie = -i(Ve)

  wrdata models_results/pnp_mpa/run_data/fo_ib_d29b2bb9-75bb-4b53-be8f-7cbd9ff6aae2_hbt_typ.csv v(c) ic ie v(b)
  quit
.endc

* ============================================================================================
* ------------------------------------- CIR/MODELS-SETUP -------------------------------------
* ============================================================================================

**************************
*including files & models*
**************************

.lib ../../../../libs.tech/ngspice/models/cornerHBT.lib hbt_typ

.end
